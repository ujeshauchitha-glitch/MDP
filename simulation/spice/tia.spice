*******************************************************************
* TrustSense Layer 1 / Part 1 - Photodiode Transimpedance Amplifier
* Two-stage Miller-compensated op-amp, shunt-feedback TIA
* Feedback element: MOS-bipolar pseudo-resistor (Rf ~ 1 GOhm incremental)
* Process: SkyWater sky130A
*
* NOTE: device sizes / currents below are hand-calculated starting
* points (see docs/TIA-DESIGN.md for the derivation). They have NOT
* been executed in ngspice yet in this environment - run
* simulation/spice/run-tia-sim.sh with $PDK_ROOT set to confirm, then
* trim Cf / device W,L to converge on the target 4.8-5.0kHz -3dB point.
*******************************************************************

* Model library: generated by run-tia-sim.sh (sky130_min.lib, tt corner, only the
* devices this block uses). Devices are subcircuits -> instantiate with X, and
* W/L are in um, so .option scale=1u is required.
.include "sky130_min.lib"
.option scale=1u

.global vdpwr vgnd vcm

* The pseudo-resistor makes the DC loop weakly defined and the circuit has a
* second, latched stable state (amp_out railed). Steer the solver to the
* intended one.
.nodeset v(photodiode_in)=1.65 v(tia_out)=1.65 v(amp_out)=1.8 v(n2out)=1.1

*=================================================================
* Supplies
*=================================================================
VPWR   vdpwr  0        DC 3.3
VGND   vgnd   0        DC 0
VCM    vcm    0        DC 1.65

*=================================================================
* Photodiode model
* Reverse-biased photodiode: current source + junction cap + series R
* + shunt (dark leakage) resistance. Cathode drives the TIA summing
* node (photodiode_in); anode returned to vgnd.
*=================================================================
Iph      anode_int  photodiode_in   DC 0 AC 1p PULSE(0 1p 100u 1n 1n 500u 2m)
Cj       photodiode_in  anode_int   10p
Rs       anode_int  vgnd            100
* No shunt resistor: dark leakage is pA-level and belongs in Iph's DC term.
* A resistive Rsh (even 1T) beats the pseudo-resistor's pA-level DC path
* and latches the loop at the wrong operating point (found in sim).

*=================================================================
* Bias reference branch (~2uA reference, mirrored around the chip)
*   M8   : NMOS diode reference, sets 2uA via Rbias
*   M8n  : NMOS mirror device, pulls the same 2uA out of node 'pbias'
*   M8p  : PMOS diode, self-biases to source 2uA into 'pbias'
*          -> node 'pbias' is now a clean PMOS gate-bias reference
*=================================================================
Rbias    vdpwr   nbias   1.2Meg
XM8       nbias   nbias   vgnd   vgnd   sky130_fd_pr__nfet_g5v0d10v5  W=4  L=2
XM8n      pbias   nbias   vgnd   vgnd   sky130_fd_pr__nfet_g5v0d10v5  W=4  L=2
XM8p      pbias   pbias   vdpwr  vdpwr  sky130_fd_pr__pfet_g5v0d10v5  W=4  L=2

*=================================================================
* Stage 1: PMOS-input differential pair, 5T OTA
*   M1/M2 : input pair             (4uA/leg, tail = 8uA)
*   M3/M4 : NMOS mirror load
*   M5    : PMOS tail current source, mirrored off 'pbias' (4x ref -> 8uA)
*=================================================================
XM5       tail1   pbias   vdpwr  vdpwr  sky130_fd_pr__pfet_g5v0d10v5  W=16  L=2
XM1       n1out   photodiode_in  tail1  vdpwr  sky130_fd_pr__pfet_g5v0d10v5  W=40  L=2
XM2       n2out   vcm            tail1  vdpwr  sky130_fd_pr__pfet_g5v0d10v5  W=40  L=2
XM3       n1out   n1out  vgnd  vgnd     sky130_fd_pr__nfet_g5v0d10v5  W=20  L=2
XM4       n2out   n1out  vgnd  vgnd     sky130_fd_pr__nfet_g5v0d10v5  W=20  L=2

*=================================================================
* Stage 2: common-source NMOS gain stage w/ PMOS current-source load
*   M6 : gain device (10uA)
*   M7 : PMOS current source load, mirrored off 'pbias' (5x ref -> 10uA)
* Miller compensation Cc + nulling resistor Rz, node n2out -> amp_out
*=================================================================
XM6       amp_out  n2out   vgnd    vgnd  sky130_fd_pr__nfet_g5v0d10v5  W=20  L=2
XM7       amp_out  pbias   vdpwr   vdpwr sky130_fd_pr__pfet_g5v0d10v5  W=20  L=2

Cc       n2out       amp_out_cc  4.2p
Rz       amp_out_cc  amp_out     11k

*=================================================================
* Output buffer: NMOS source follower, drives TIA output / next stage
* (PGA) input capacitance. M10 tail mirrored off 'nbias' (3.2x ref -> 6.4uA)
*=================================================================
XM9       vdpwr    amp_out  tia_out  vgnd  sky130_fd_pr__nfet_g5v0d10v5  W=20    L=1
XM10      tia_out  nbias    vgnd     vgnd  sky130_fd_pr__nfet_g5v0d10v5  W=12.8  L=2
Cload    tia_out  vgnd     2p

*=================================================================
* Feedback network: MOS-bipolar pseudo-resistor (Rf ~ 1 GOhm
* incremental resistance around the virtual-ground bias point) +
* explicit small compensation cap Cf.
* Two thin-oxide PMOS, gate+drain tied to the shared mid node, body tied to
* own source (n-well process, no deep-nwell needed). Symmetric for either
* sign of small-signal current. The original NMOS version (gates tied to the
* outer terminals, bulk at gnd) was one-sided: it measured ~650 GOhm and
* could not pull the input to VCM. This version, W=100um L=0.15um m=2 per
* device, measures ~0.94 GOhm. (Tied both ends near VCM, so 1.8V devices are
* safe.)
*=================================================================
XMPR1    pr_mid  pr_mid  photodiode_in  photodiode_in  sky130_fd_pr__pfet_01v8  W=94  L=0.15  m=2
XMPR2    pr_mid  pr_mid  tia_out        tia_out        sky130_fd_pr__pfet_01v8  W=94  L=0.15  m=2

Cf       photodiode_in  tia_out  1f

*=================================================================
* Analysis
*=================================================================
.control
  op
  print v(photodiode_in) v(tia_out) v(amp_out) v(nbias) v(pbias)
  let power_op = -i(VPWR) * 3.3
  print power_op

  ac dec 50 10 100k
  let gain_v_per_a = mag(v(tia_out)) / 1p
  let vdb_out = db(v(tia_out))
  meas ac gain_dc find gain_v_per_a at=10
  meas ac gain_db_dc find vdb_out at=10
  meas ac bw_3db when vdb_out=(gain_db_dc-3)
  meas ac vdb_max MAX vdb_out
  let peaking_db = vdb_max - gain_db_dc
  print peaking_db
  print gain_dc bw_3db
  wrdata tia_ac.txt vdb_out

  * output noise integrated 10Hz-100kHz, referred back to input current
  noise v(tia_out) Iph dec 50 10 100k
  print inoise_total onoise_total
  let noise_rti = onoise_total / gain_v_per_a
  print noise_rti

  tran 1u 1m 0 1u
  * 1 pA step at t=100us; measure the 10-90% edge of the 1 mV output step (the TIA inverts, so it falls)
  meas tran vbase FIND v(tia_out) AT=99u
  meas tran vtop  MIN  v(tia_out) FROM=100u TO=590u
  meas tran trise TRIG v(tia_out) VAL='vbase+0.1*(vtop-vbase)' FALL=1 TD=100u
  +                TARG v(tia_out) VAL='vbase+0.9*(vtop-vbase)' FALL=1 TD=100u
  let power_inst = -i(VPWR) * 3.3
  meas tran power_total AVG power_inst FROM=0 TO=1m
  wrdata tia_tran.txt v(tia_out)

  write tia.raw
  quit
.endc

.end
