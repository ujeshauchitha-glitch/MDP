*******************************************************************
* TrustSense Layer 1 - AFE front end: regulated-cascode input node +
* 1:1 current mirror feeding the slow (PPG) and wideband (perturbation)
* TIAs. GENERATED by tools/gen_afe.py from tia.spice / tia_wide.spice.
*
*   photodiode -> X (held low-Z by regulated cascode Mc/Mb/Ib)
*   Mc sinks Iph into mirror diode Mm; Mo1 -> slow TIA, Mo2 -> wide TIA
*******************************************************************
.include "sky130_min.lib"
.option scale=1u
.global vdpwr vgnd vcm
.nodeset v(x)=1.0 v(dmir)=0.6 v(gc)=0.4 v(s_in)=1.65 v(w_in)=1.65 v(s_out)=1.65 v(w_out)=1.65
+ v(amp_out_s)=1.8 v(n2out_s)=1.1 v(amp_out_w)=1.8 v(n2out_w)=1.1

VPWR vdpwr 0 DC 3.3
VGND vgnd  0 DC 0
VCM  vcm   0 DC 1.65

* Photodiode: signal current + DC (I_DC) into node x
Iph  anode_int x  DC {IDC} AC 1n
Cj   x anode_int  10p
Rs   anode_int vgnd 100

* ---- regulated-cascode input (PMOS cascode: Iph flows INTO x, through
* Mc source->drain, into the NMOS mirror diode) ----
* Mb: NMOS CS booster, gate = x, drain = gc (inverting: x up -> gc down ->
* Mc conducts more -> pulls x back down = negative feedback). Ib pulls gc up.
XMc  dmir gc x vdpwr sky130_fd_pr__pfet_g5v0d10v5 W=20 L=1
XMb  gc   x vgnd vgnd sky130_fd_pr__nfet_g5v0d10v5 W=1  L=8
XMib gc   pbias_b vdpwr vdpwr sky130_fd_pr__pfet_g5v0d10v5 W=4 L=2
XMibd pbias_b pbias_b vdpwr vdpwr sky130_fd_pr__pfet_g5v0d10v5 W=4 L=2
Rib   pbias_b vgnd 1.5Meg

* Fixed bias current IBX held through Mc/Mm so gm (and hence input-node
* impedance) does not collapse with the photocurrent. IDEAL source for now
* (to become a PMOS mirror). The wide path is AC-coupled downstream so its
* IBX offset only shifts DC; the slow path needs it cancelled: Icomp is an
* IDEAL stand-in for a DC servo (NOT designed yet).
Ibx   vdpwr x DC {IBX}
Icomp vdpwr s_in DC {IBX+IDC}
Icompw vdpwr w_in DC {IBX}

* ---- 1:1 mirror, long L for accuracy ----
XMm  dmir dmir vgnd vgnd sky130_fd_pr__nfet_g5v0d10v5 W=20 L=2
XMo1 w_in dmir vgnd vgnd sky130_fd_pr__nfet_g5v0d10v5 W=20 L=2
XMo2 s_in dmir vgnd vgnd sky130_fd_pr__nfet_g5v0d10v5 W=20 L=2

* ===== slow TIA =====
*=================================================================
* Bias reference branch (~2uA reference, mirrored around the chip)
*   M8   : NMOS diode reference, sets 2uA via Rbias
*   M8n  : NMOS mirror device, pulls the same 2uA out of node 'pbias'
*   M8p  : PMOS diode, self-biases to source 2uA into 'pbias'
*          -> node 'pbias' is now a clean PMOS gate-bias reference
*=================================================================
Rbias_s vdpwr nbias_s 1.2Meg
XM8_s nbias_s nbias_s vgnd vgnd sky130_fd_pr__nfet_g5v0d10v5 W=4 L=2
XM8n_s pbias_s nbias_s vgnd vgnd sky130_fd_pr__nfet_g5v0d10v5 W=4 L=2
XM8p_s pbias_s pbias_s vdpwr vdpwr sky130_fd_pr__pfet_g5v0d10v5 W=4 L=2

*=================================================================
* Stage 1: PMOS-input differential pair, 5T OTA
*   M1/M2 : input pair             (4uA/leg, tail = 8uA)
*   M3/M4 : NMOS mirror load
*   M5    : PMOS tail current source, mirrored off 'pbias' (4x ref -> 8uA)
*=================================================================
XM5_s tail1_s pbias_s vdpwr vdpwr sky130_fd_pr__pfet_g5v0d10v5 W=16 L=2
XM1_s n1out_s s_in tail1_s vdpwr sky130_fd_pr__pfet_g5v0d10v5 W=40 L=2
XM2_s n2out_s vcm tail1_s vdpwr sky130_fd_pr__pfet_g5v0d10v5 W=40 L=2
XM3_s n1out_s n1out_s vgnd vgnd sky130_fd_pr__nfet_g5v0d10v5 W=20 L=2
XM4_s n2out_s n1out_s vgnd vgnd sky130_fd_pr__nfet_g5v0d10v5 W=20 L=2

*=================================================================
* Stage 2: common-source NMOS gain stage w/ PMOS current-source load
*   M6 : gain device (10uA)
*   M7 : PMOS current source load, mirrored off 'pbias' (5x ref -> 10uA)
* Miller compensation Cc + nulling resistor Rz, node n2out -> amp_out
*=================================================================
XM6_s amp_out_s n2out_s vgnd vgnd sky130_fd_pr__nfet_g5v0d10v5 W=20 L=2
XM7_s amp_out_s pbias_s vdpwr vdpwr sky130_fd_pr__pfet_g5v0d10v5 W=20 L=2

Cc_s n2out_s amp_out_cc_s 4.2p
Rz_s amp_out_cc_s amp_out_s 11k

*=================================================================
* Output buffer: NMOS source follower, drives TIA output / next stage
* (PGA) input capacitance. M10 tail mirrored off 'nbias' (3.2x ref -> 6.4uA)
*=================================================================
XM9_s vdpwr amp_out_s s_out vgnd sky130_fd_pr__nfet_g5v0d10v5 W=20 L=1
XM10_s s_out nbias_s vgnd vgnd sky130_fd_pr__nfet_g5v0d10v5 W=12.8 L=2
Cload_s s_out vgnd 2p

*=================================================================
* Feedback network: MOS-bipolar pseudo-resistor (Rf ~ 1 GOhm
* incremental resistance around the virtual-ground bias point) +
* explicit small compensation cap Cf.
* Two thin-oxide PMOS, gate+drain tied to the shared mid node, body tied to
* own source (n-well process, no deep-nwell needed). Symmetric for either
* sign of small-signal current. The original NMOS version (gates tied to the
* outer terminals, bulk at gnd) was one-sided: it measured ~650 GOhm and
* could not pull the input to VCM. This version, W=100um L=0.15um m=2 per
* device, measures ~0.94 GOhm. (Tied both ends near VCM, so 1.8V devices are
* safe.)
*=================================================================
XMPR1_s pr_mid_s pr_mid_s s_in s_in sky130_fd_pr__pfet_01v8 W=94 L=0.15 m=2
XMPR2_s pr_mid_s pr_mid_s s_out s_out sky130_fd_pr__pfet_01v8 W=94 L=0.15 m=2

Cf_s s_in s_out 1f
* ===== wideband TIA =====
*=================================================================
* Bias reference branch (~2uA reference, mirrored around the chip)
*   M8   : NMOS diode reference, sets 2uA via Rbias
*   M8n  : NMOS mirror device, pulls the same 2uA out of node 'pbias'
*   M8p  : PMOS diode, self-biases to source 2uA into 'pbias'
*          -> node 'pbias' is now a clean PMOS gate-bias reference
*=================================================================
Rbias_w vdpwr nbias_w 600k
XM8_w nbias_w nbias_w vgnd vgnd sky130_fd_pr__nfet_g5v0d10v5 W=4 L=2
XM8n_w pbias_w nbias_w vgnd vgnd sky130_fd_pr__nfet_g5v0d10v5 W=4 L=2
XM8p_w pbias_w pbias_w vdpwr vdpwr sky130_fd_pr__pfet_g5v0d10v5 W=4 L=2

*=================================================================
* Stage 1: PMOS-input differential pair, 5T OTA
*   M1/M2 : input pair             (4uA/leg, tail = 8uA)
*   M3/M4 : NMOS mirror load
*   M5    : PMOS tail current source, mirrored off 'pbias' (4x ref -> 8uA)
*=================================================================
XM5_w tail1_w pbias_w vdpwr vdpwr sky130_fd_pr__pfet_g5v0d10v5 W=16 L=2
XM1_w n1out_w w_in tail1_w vdpwr sky130_fd_pr__pfet_g5v0d10v5 W=40 L=2
XM2_w n2out_w vcm tail1_w vdpwr sky130_fd_pr__pfet_g5v0d10v5 W=40 L=2
XM3_w n1out_w n1out_w vgnd vgnd sky130_fd_pr__nfet_g5v0d10v5 W=20 L=2
XM4_w n2out_w n1out_w vgnd vgnd sky130_fd_pr__nfet_g5v0d10v5 W=20 L=2

*=================================================================
* Stage 2: common-source NMOS gain stage w/ PMOS current-source load
*   M6 : gain device (10uA)
*   M7 : PMOS current source load, mirrored off 'pbias' (5x ref -> 10uA)
* Miller compensation Cc + nulling resistor Rz, node n2out -> amp_out
*=================================================================
XM6_w amp_out_w n2out_w vgnd vgnd sky130_fd_pr__nfet_g5v0d10v5 W=20 L=2
XM7_w amp_out_w pbias_w vdpwr vdpwr sky130_fd_pr__pfet_g5v0d10v5 W=20 L=2

Cc_w n2out_w amp_out_cc_w 2p
Rz_w amp_out_cc_w amp_out_w 11k

*=================================================================
* Output buffer: NMOS source follower, drives TIA output / next stage
* (PGA) input capacitance. M10 tail mirrored off 'nbias' (3.2x ref -> 6.4uA)
*=================================================================
XM9_w vdpwr amp_out_w w_out vgnd sky130_fd_pr__nfet_g5v0d10v5 W=20 L=1
XM10_w w_out nbias_w vgnd vgnd sky130_fd_pr__nfet_g5v0d10v5 W=12.8 L=2
Cload_w w_out vgnd 2p

*=================================================================
* Feedback network: MOS-bipolar pseudo-resistor (Rf ~ 1 GOhm
* incremental resistance around the virtual-ground bias point) +
* explicit small compensation cap Cf.
* Two thin-oxide PMOS, gate+drain tied to the shared mid node, body tied to
* own source (n-well process, no deep-nwell needed). Symmetric for either
* sign of small-signal current. The original NMOS version (gates tied to the
* outer terminals, bulk at gnd) was one-sided: it measured ~650 GOhm and
* could not pull the input to VCM. This version, W=100um L=0.15um m=2 per
* device, measures ~0.94 GOhm. (Tied both ends near VCM, so 1.8V devices are
* safe.)
*=================================================================
Rf_w w_in w_out 314k

Cf_w w_in w_out 1.4p

.param IDC=10n
.param IBX=1u
.control
  op
  print v(x) v(dmir) v(gc) v(s_in) v(s_out) v(w_in) v(w_out)
  let p = -i(VPWR)*3.3
  print p
  quit
.endc
.end
